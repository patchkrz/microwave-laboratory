# Ansys Electronics Desktop project, version 2020.2
materials:
  vacuum: permittivity=1
  Taconic RF-30 (tm): permittivity=3 dielectric_loss_tangent=0.0014

design SMA_simulation (HFSS, DrivenModal, model units mm)
variables:
  subX = 20mm
  subY = 30mm
  subH = 1.5mm
  MW = 1.8mm
  g = 0.2mm
geometry:
  substrate [Taconic RF-30 (tm)] = box(corner=(-subX/2, 0mm, 0mm), size=(subX, subY, -subH))
  Ground = rectangle(corner=(-10mm, 30mm, -1.5mm), x_size=20mm, y_size=-30mm)
  Microstrip = rectangle(corner=(-MW/2, g, 0mm), x_size=MW, y_size=subY-2*g)
  coordinate_system RelativeCS1 = origin=(0mm, subY, 0mm) x=(1mm, 0mm, 0mm) y=(0mm, 1mm, 0mm)
  coordinate_system radiation_box_CS = origin=(0mm, -subY/2, 0mm) x=(1mm, 0mm, 0mm) y=(0mm, 1mm, 0mm) in RelativeCS1
  radiation_box [vacuum] = box(corner=(-15mm, -21.5mm, -5mm), size=(30mm, 43mm, 15mm)) in radiation_box_CS
  SMA_conn_CS_2_1 = component(SMA_conn_CS_2, 3D_Component_File_Path="C:/Users/EFE/Documents/ANSYS_workspace/Mikrodalga Lab/Lab 1/SMA_conn_NM_2.a3dcomp", SX=7.35mm, SY=2.5mm, SZ=6.35mm, subH=1.5mm, pinD=0.36mm, pinL=1.5mm, in=0.43mm, OutD=2.6mm, OutL=4mm, TefD=2.2mm, innerD=0.63mm)
  SMA_body_1, arm1_3, arm2_3, arm1_1_3, arm2_1_3, Center_pin_1, inner_pin_1_3, Outer_cond_1, inner_cond_1 [pec] = part_of(SMA_conn_CS_2_1)
  Circle1 [vacuum] = part_of(SMA_conn_CS_2_1)
  SMA_conn_CS_2_2 = component(SMA_conn_CS_2, 3D_Component_File_Path="C:/Users/EFE/Documents/ANSYS_workspace/Mikrodalga Lab/Lab 1/SMA_conn_NM_2.a3dcomp", SX=7.35mm, SY=2.5mm, SZ=6.35mm, subH=1.5mm, pinD=0.36mm, pinL=1.5mm, in=0.43mm, OutD=2.6mm, OutL=4mm, TefD=2.2mm, innerD=0.63mm)
  SMA_body2, arm1_2, arm2_2, arm1_1_2, arm2_1_2, Center_pin2, inner_pin_1_2, Outer_cond2, inner_cond2 [pec] = part_of(SMA_conn_CS_2_2) in RelativeCS1
  Circle1_2 [vacuum] = part_of(SMA_conn_CS_2_2) in RelativeCS1
  SMA_conn_CS_2_2.rotate(RotateAxis=Z RotateAngle=-180deg) in RelativeCS1
boundaries and excitations:
  PerfE1: Perfect E Objects=Ground
  PerfE2: Perfect E Objects=Microstrip
  Rad1: Radiation Objects=radiation_box
  SMA_conn_CS_2_1_1: Wave Port Objects=Circle1 NumModes=1 Modes{Mode1{CharImp=Zpi}}
  SMA_conn_CS_2_2_1: Wave Port Objects=Circle1_2 NumModes=1 Modes{Mode1{CharImp=Zpi}}
setups:
  Setup1: HfssDrivenAuto AutoSolverSetting=Balanced SaveAnyFields=false Type=Interpolating
    sweep Sweep: 1GHz to 10GHz step 0.02GHz;
source amplitudes:
  SMA_conn_CS_2_1_1:1: 1W 0deg
  SMA_conn_CS_2_2_1:1: 0W 0deg
reports:
  S Parameter Plot 1: dB(S(SMA_conn_CS_2_1_1,SMA_conn_CS_2_1_1)), dB(S(SMA_conn_CS_2_2_1,SMA_conn_CS_2_1_1)) vs Freq on Setup1 : Sweep
